** sch_path: /foss/designs/opamp/MOS_characteristics.sch
**.subckt MOS_characteristics
XM1 drain gate GND GND sg13_lv_nmos w=0.15u l=0.13u ng=1 m=1
V1 gate GND 1.5
V2 drain GND 2
**** begin user architecture code

.lib cornerMOSlv.lib mos_tt
.lib cornerMOShv.lib mos_tt
.lib cornerHBT.lib hbt_typ
.lib cornerRES.lib res_typ
.lib cornerCAP.lib cap_typ

**** end user architecture code
**.ends
.GLOBAL GND
.end
